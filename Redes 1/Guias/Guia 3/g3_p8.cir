* C:\Users\Mariano\Desktop\D+I\docencia\redes 1\Guias\Guia 3\g3_p8.sch

* Schematics Version 9.1 - Web Update 1
* Wed Aug 30 12:25:01 2023

** Analysis setup **
.OP

* From [PSPICE NETLIST] section of pspiceev.ini:
.lib "nom.lib"

.INC "g3_p8.net"
.INC "g3_p8.als"

.probe

.END
