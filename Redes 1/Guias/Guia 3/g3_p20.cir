* C:\Users\Mariano\Desktop\D+I\docencia\redes 1\Guias\Guia 3\g3_p20.sch

* Schematics Version 9.1 - Web Update 1
* Thu Sep 14 11:58:43 2023

** Analysis setup **
.OP

* From [PSPICE NETLIST] section of pspiceev.ini:
.lib "nom.lib"

.INC "g3_p20.net"
.INC "g3_p20.als"

.probe

.END
