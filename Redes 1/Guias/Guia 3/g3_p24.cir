* C:\Users\Mariano\Desktop\D+I\docencia\redes 1\Guias\Guia 3\g3_p24.sch

* Schematics Version 9.1 - Web Update 1
* Tue Sep 19 09:57:56 2023

** Analysis setup **
.tran .02 2
.OP

* From [PSPICE NETLIST] section of pspiceev.ini:
.lib "nom.lib"

.INC "g3_p24.net"
.INC "g3_p24.als"

.probe

.END
