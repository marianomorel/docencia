* C:\Users\Mariano\Desktop\D+I\docencia\redes 1\Guias\Guia 1\g1_p3.sch

* Schematics Version 9.1 - Web Update 1
* Fri Aug 04 13:08:20 2023

** Analysis setup **
.tran .001 5
.OP

* From [PSPICE NETLIST] section of pspiceev.ini:
.lib "nom.lib"

.INC "g1_p3.net"
.INC "g1_p3.als"

.probe

.END
