* C:\Users\Mariano\Desktop\D+I\docencia\redes 1\Guias\Guia 1\g1_p4.sch

* Schematics Version 9.1 - Web Update 1
* Fri Aug 04 13:25:48 2023

** Analysis setup **
.tran .001 3
.OP

* From [PSPICE NETLIST] section of pspiceev.ini:
.lib "nom.lib"

.INC "g1_p4.net"
.INC "g1_p4.als"

.probe

.END
