* C:\Users\Mariano\Desktop\D+I\docencia\redes 1\Guias\Guia 1\g1_p2.sch

* Schematics Version 9.1 - Web Update 1
* Fri Aug 04 12:53:40 2023

** Analysis setup **
.tran .001 6
.OP

* From [PSPICE NETLIST] section of pspiceev.ini:
.lib "nom.lib"

.INC "g1_p2.net"
.INC "g1_p2.als"

.probe

.END
