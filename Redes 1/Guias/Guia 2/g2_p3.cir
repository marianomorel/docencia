* C:\Users\Mariano\Desktop\D+I\docencia\redes 1\Guias\Guia 2\g2_p3.sch

* Schematics Version 9.1 - Web Update 1
* Mon Aug 14 14:02:10 2023

** Analysis setup **
.LOADBIAS ""
.OP

* From [PSPICE NETLIST] section of pspiceev.ini:
.lib "nom.lib"

.INC "g2_p3.net"
.INC "g2_p3.als"

.probe

.END
