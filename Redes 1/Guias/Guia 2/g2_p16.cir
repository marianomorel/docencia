* C:\Users\Mariano\Desktop\D+I\docencia\redes 1\Guias\Guia 2\g2_p16.sch

* Schematics Version 9.1 - Web Update 1
* Mon Aug 14 15:23:29 2023

** Analysis setup **
.tran .0001 3.1
.OP

* From [PSPICE NETLIST] section of pspiceev.ini:
.lib "nom.lib"

.INC "g2_p16.net"
.INC "g2_p16.als"

.probe

.END
