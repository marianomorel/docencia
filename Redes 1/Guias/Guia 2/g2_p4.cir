* C:\Users\Mariano\Desktop\D+I\docencia\redes 1\Guias\Guia 2\g2_p4.sch

* Schematics Version 9.1 - Web Update 1
* Mon Aug 14 14:05:03 2023

** Analysis setup **
.tran .0001 .1 0 .0001
.OP

* From [PSPICE NETLIST] section of pspiceev.ini:
.lib "nom.lib"

.INC "g2_p4.net"
.INC "g2_p4.als"

.probe

.END
