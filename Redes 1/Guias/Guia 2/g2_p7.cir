* C:\Users\Mariano\Desktop\D+I\docencia\redes 1\Guias\Guia 2\g2_p7.sch

* Schematics Version 9.1 - Web Update 1
* Mon Aug 14 14:26:15 2023

** Analysis setup **
.OP

* From [PSPICE NETLIST] section of pspiceev.ini:
.lib "nom.lib"

.INC "g2_p7.net"
.INC "g2_p7.als"

.probe

.END
