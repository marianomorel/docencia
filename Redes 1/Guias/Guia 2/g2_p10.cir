* C:\Users\Mariano\Desktop\D+I\docencia\redes 1\Guias\Guia 2\g2_p10.sch

* Schematics Version 9.1 - Web Update 1
* Mon Aug 14 14:40:12 2023

** Analysis setup **
.tran .01 1
.OP

* From [PSPICE NETLIST] section of pspiceev.ini:
.lib "nom.lib"

.INC "g2_p10.net"
.INC "g2_p10.als"

.probe

.END
